* Amplificador Emissor Comum com Defeito (R_C=47k saturando Q1)
V_CC VCC 0 12
V_IN IN 0 SINE(0 10m 1k)
C_IN IN BASE 10u
R1 VCC BASE 47k
R2 BASE 0 10k
Q1 COL BASE EMI 2N3904
R_C VCC COL 47k
R_E EMI 0 1k
C_OUT COL OUT 10u
R_LOAD OUT 0 10k
.model 2N3904 NPN(Is=6.734f Bf=416.4 Vaf=74.03)
.tran 0 5m 1m 2u
.meas TRAN v_col_dc AVG V(COL)
.meas TRAN v_in_pp PP V(IN)
.meas TRAN v_out_pp PP V(OUT)
.meas TRAN gain_vv PARAM v_out_pp/v_in_pp
.end
