* 1 MHz RLC Series-Shunt Bandpass Filter
VIN IN 0 AC 1
RS IN OUT 1k
L1 OUT 0 10u Rser=0.5
C1 OUT 0 2.4n
.ac dec 500 100k 10Meg
.meas ac VMAX MAX mag(V(OUT))
.meas ac F0 WHEN ph(V(OUT))=0
.meas ac ATTEN_100K FIND mag(V(OUT)) AT 100k
.end
