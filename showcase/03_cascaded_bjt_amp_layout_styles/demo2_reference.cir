* 2-Stage Cascaded BJT Amplifier + Emitter-Follower Buffer
VCC VCC_12V 0 12
VIN IN 0 SINE(0 0.05 1k)
CIN IN B1 10u
R1 VCC_12V B1 47k
R2 B1 0 12k
RC1 VCC_12V C1 2.2k
Q1 C1 B1 E1 2N2222
RE1A E1 E1_MID 220
RE1B E1_MID 0 470
CE1 E1_MID 0 100u
CMID C1 B2 10u
R3 VCC_12V B2 22k
R4 B2 0 22k
Q2 VCC_12V B2 E2 2N2222
RE2 E2 0 470
COUT E2 OUT 47u
RLOAD OUT 0 100
.tran 0 5m 0 2u
.meas tran VIN_PP PP V(IN) FROM=2m TO=5m
.meas tran VOUT_PP PP V(OUT) FROM=2m TO=5m
.meas tran AV_TOTAL PARAM VOUT_PP/VIN_PP
.end
